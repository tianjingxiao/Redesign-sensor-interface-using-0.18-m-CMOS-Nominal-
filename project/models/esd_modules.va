// Path, Component, Release: cmrf7sf/rel/Spectre/models/esd_modules.va, rf7sf_models, mod_cmrf7sf
// CMVC Revision: 1.1 09/11/20 08:54:14
//***********************************************************************
//*
//*   Licensed Materials - Property of IBM
//*   IBM Confidential
//*   (C) 2009 IBM Corporation
//*   US Government Users Restricted Rights - Use, duplication
//*   or disclosure restricted by GSA ADP Schedule contract with
//*   IBM Corporation.
//************************************************************************
//
// esd_modules.va
//
//Verilog-A model for esdvpnp

`include "constants.vams"
`include "disciplines.vams"
module It2_monitor (v1, v2);
inout v1, v2;
electrical v1, v2;
parameter real rdummy    = 1e-3; //dummy resistor
parameter real keyp      = 1;    //key dimension parameter for failure current scaling.
                                 //For Diode, keyp is perimeter. For MOSFET, key is channel width.
parameter real It2       = 1;    //ESD failure current density (mA/um).
parameter integer esd_event  = 0      from [0:3]; // switch for esd_event
parameter integer esd_exit   = 1      from [0:1]; // switch for esd_exit
parameter real It_valid	 = 1000;
real I1;
analog begin
  I1 = V(v1,v2)/rdummy;
  if (I1>It_valid) begin
     if (esd_exit==1) begin $strobe("[IBMESD_ERR_301] Device %m: ESD high current failure at %f A,model is not validated for higher currents, simulator exited.", I1); $finish(0); end
     else             begin $strobe("[IBMESD_ERR_301] Device %m: ESD high current failure at %f A,model is not validated for higher currents.", I1); end
  end
  // ESD failure detection
  if (V(v1,v2)>(rdummy*It2*1e6*keyp)) begin
     if (esd_exit==1) begin $strobe("[IBMESD_ERR_301] Device %m: ESD high current failure at %f A, simulator exited.", I1); $finish(0); end
     else             begin $strobe("[IBMESD_ERR_301] Device %m: ESD high current failure at %f A.", I1); end
  end

  I(v1,v2) <+ I1;
end

endmodule
