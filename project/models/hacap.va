// Path, Component, Release: cmos7base/rel/Spectre/models/hacap.va, tech7_models, mod_cmos7base
// CMVC Revision: 1.1 09/08/26 07:43:44
//
// VerilogA model for 7RF and 7WL HA Varactor
// IBM CONFIDENTIAL
// (C) 2009 IBM Corporation

`include "constants.vams"
`include "disciplines.vams"

module havarcap (an, ca);
inout an, ca;
electrical an, ca;

parameter real (* integer inherited_mfactor; *) m=1;
parameter real pareac=0p from [0.0:inf);
parameter real ax_ha=5.1e16;
parameter real kx_ha=-1.01;
parameter real az_ha=5.1e16;
parameter real kz_ha=-4.63;
parameter real ay_ha=1.2e15;
parameter real ky_ha=0.22;
parameter real vbi_ha=1.0;
parameter real deltemp=0;
parameter real epsil=3.044023e-3;
parameter real lkpre_ha=0;
parameter real lkvfac_ha=1.3;
parameter real satcurr_ha=0;
parameter real foridea_ha=1.02;
parameter real ego = 1.11;
parameter real vbit_ha=1.1m;
real ax, kx, ay, ky, az, kz, vbi, v, delx;
real Bo, B, vx, vy, vz;
real Dx, Dy, Dtot, xz, xo, xx;
real vtot, diffx, diffy, diff, q;
real lkpre, lkvfac, satcurr, foridea, dcamp;
real egto, egt, xti, alf, bet, xfac;
integer i;
   analog begin
      Bo = `P_Q/(`P_K*298.15);
      B = `P_Q/(`P_K*(298.15+deltemp));
      alf = 4.73e-4;
      bet = 636.0;
      xti = 3.0;
      egto = ego - alf*(298.15)*(298.15)/(bet+298.15);
      egt = ego - alf*(298.15+deltemp)*(298.15+deltemp)/(bet+298.15+deltemp);
      xfac = xti*ln((298.15+deltemp)/298.15) - (B*egt - Bo*egto);
      kx = kx_ha;
      kz = kz_ha;
      ky = ky_ha;
      delx = ln(az_ha/ax_ha)/(kx-kz);
      ax = `P_Q*ax_ha*exp(kx*delx);
      az = -`P_Q*az_ha*exp(kz*delx);
      ay = `P_Q*ay_ha*exp(ky*delx);
      vbi = vbi_ha - vbit_ha*deltemp;
      lkpre = lkpre_ha;
      lkvfac = lkvfac_ha;
      satcurr = satcurr_ha;
      foridea = foridea_ha;
      v = V(an,ca);
      if (v <= 0.0)
        dcamp = m*lkpre*sinh(lkvfac*v);
      else
        dcamp = m*satcurr*exp(xfac)*exp(B*v/foridea);
      xz = 3.0 + 0.0*v;
      for (i=1; i<=40; i=i+1) begin
         xo=xz;
         vx = (ax/(epsil*kx*kx))*((1.0- kx*xo)*exp(kx*xo) - 1.0);
         vy = (ay/(epsil*ky*ky))*((1.0- ky*xo)*exp(ky*xo) - 1.0);
         Dx = (ax/kx)*(1.0 - exp(kx*xo));
         Dy = (ay/ky)*(1.0 - exp(ky*xo));
         Dtot = Dx+Dy;
         xx = (1.0/kz)*ln(1.0 - (kz/az)*Dtot);
         vz = (az/(epsil*kz*kz))*((1.0- kz*xx)*exp(kz*xx) - 1.0);
         vtot = vz-vx-vy;
         diffx = -ax/(epsil)*xo*exp(kx*xo);
         diffy = -ay/(epsil)*xo*exp(ky*xo);
         diff = (-1.0+(xx/xo))*(diffx+diffy);
         xz = xo - (vtot-vbi+v)/(diff+1e-20)/2.0;
      end
      q = m*pareac*((ax/kx)*(1.0-exp(kx*xz)) + (ay/ky)*(1.0-exp(ky*xz)));
      I(an,ca) <+ ddt(q) + dcamp;
//      $strobe("v = %e q = %e", v, iwatch);
   end

endmodule
